// SPDX-License-Identifier: BSD-2-Clause
// USB Wishbone Bridge CSR Definition
//
// Copyright (c) 2025-2026 Shareef Jalloq
//
// SystemRDL register definitions for the USB Wishbone Bridge.
// Regenerate SV: source sourceme && make -C hw/ip/usb_bridge/rdl

addrmap usb_bridge_csr {
    name = "USB Wishbone Bridge CSRs";
    desc = "Register interface for CPU<->USB Host communication via FIFOs";

    default regwidth = 32;

    // TX_DATA - Write data to TX FIFO (write-only, external)
    // External register: data written here is captured by hw logic
    reg tx_data_reg {
        name = "TX Data";
        desc = "Write data to TX FIFO. Each write pushes one word.";

        field {
            sw = w;
            hw = r;
        } data[31:0] = 0;
    };

    // RX_DATA - Read data from RX FIFO (read-only, external with auto-pop)
    reg rx_data_reg {
        name = "RX Data";
        desc = "Read data from RX FIFO. Each read pops one word.";

        field {
            sw = r;
            hw = w;
        } data[31:0] = 0;
    };

    // STATUS - FIFO status flags (read-only from SW, written by HW)
    reg status_reg {
        name = "Status";
        desc = "FIFO status flags";

        field {
            desc = "TX FIFO ready (can accept writes)";
            sw = r;
            hw = w;
        } tx_ready[0:0] = 0;

        field {
            desc = "TX FIFO full";
            sw = r;
            hw = w;
        } tx_full[1:1] = 0;

        field {
            desc = "TX FIFO empty";
            sw = r;
            hw = w;
        } tx_empty[2:2] = 1;

        field {
            desc = "RX FIFO has valid data (can read)";
            sw = r;
            hw = w;
        } rx_valid[3:3] = 0;

        field {
            desc = "RX FIFO full";
            sw = r;
            hw = w;
        } rx_full[4:4] = 0;

        field {
            desc = "RX FIFO empty";
            sw = r;
            hw = w;
        } rx_empty[5:5] = 1;

        field {
            desc = "TX overflow occurred (sticky, write-1-to-clear)";
            sw = rw;
            hw = w;
            onwrite = woclr;
        } tx_overflow[6:6] = 0;

        field {
            desc = "RX overflow occurred (sticky, write-1-to-clear)";
            sw = rw;
            hw = w;
            onwrite = woclr;
        } rx_overflow[7:7] = 0;
    };

    // CONTROL - Control register
    reg control_reg {
        name = "Control";
        desc = "Bridge control register";

        field {
            desc = "TX enable";
            sw = rw;
            hw = r;
        } tx_enable[0:0] = 0;

        field {
            desc = "RX enable";
            sw = rw;
            hw = r;
        } rx_enable[1:1] = 0;

        field {
            desc = "TX flush (write-1-to-trigger)";
            sw = rw;
            hw = r;
            singlepulse;
        } tx_flush[2:2] = 0;

        field {
            desc = "RX flush (write-1-to-trigger)";
            sw = rw;
            hw = r;
            singlepulse;
        } rx_flush[3:3] = 0;

        field {
            desc = "Enable timeout-based flush";
            sw = rw;
            hw = r;
        } timeout_flush_en[4:4] = 0;

        field {
            desc = "Enable threshold-based flush";
            sw = rw;
            hw = r;
        } thresh_flush_en[5:5] = 0;

        field {
            desc = "Enable character-match flush (e.g., on newline)";
            sw = rw;
            hw = r;
        } char_flush_en[6:6] = 0;

        field {
            desc = "Loopback mode (TX->RX for testing)";
            sw = rw;
            hw = r;
        } loopback[7:7] = 0;

        field {
            desc = "IRQ enable: TX FIFO empty";
            sw = rw;
            hw = r;
        } irq_tx_empty_en[8:8] = 0;

        field {
            desc = "IRQ enable: RX FIFO has data";
            sw = rw;
            hw = r;
        } irq_rx_valid_en[9:9] = 0;

        field {
            desc = "IRQ enable: TX level below watermark";
            sw = rw;
            hw = r;
        } irq_tx_low_en[10:10] = 0;

        field {
            desc = "IRQ enable: RX level above watermark";
            sw = rw;
            hw = r;
        } irq_rx_high_en[11:11] = 0;
    };

    // TX_LEVEL - TX FIFO fill level (read-only)
    reg tx_level_reg {
        name = "TX Level";
        desc = "TX FIFO fill level (number of entries)";

        field {
            sw = r;
            hw = w;
        } cnt[15:0] = 0;
    };

    // RX_LEVEL - RX FIFO fill level (read-only)
    reg rx_level_reg {
        name = "RX Level";
        desc = "RX FIFO fill level (number of entries)";

        field {
            sw = r;
            hw = w;
        } cnt[15:0] = 0;
    };

    // FLUSH_TIMEOUT - Auto-flush timeout
    reg flush_timeout_reg {
        name = "Flush Timeout";
        desc = "Timeout in clock cycles for auto-flush (0 = disabled)";

        field {
            sw = rw;
            hw = r;
        } timeout[31:0] = 10000;
    };

    // FLUSH_THRESH - TX flush threshold
    reg flush_thresh_reg {
        name = "Flush Threshold";
        desc = "TX FIFO level threshold for flush trigger";

        field {
            sw = rw;
            hw = r;
        } threshold[15:0] = 32;
    };

    // FLUSH_CHAR - Flush-on-character match
    reg flush_char_reg {
        name = "Flush Character";
        desc = "Character to match for flush trigger (default 0x0A = newline)";

        field {
            sw = rw;
            hw = r;
        } character[7:0] = 0x0A;
    };

    // TX watermark for IRQ
    reg tx_watermark_reg {
        name = "TX Watermark";
        desc = "TX level threshold for low watermark IRQ";

        field {
            sw = rw;
            hw = r;
        } threshold[15:0] = 8;
    };

    // RX watermark for IRQ
    reg rx_watermark_reg {
        name = "RX Watermark";
        desc = "RX level threshold for high watermark IRQ";

        field {
            sw = rw;
            hw = r;
        } threshold[15:0] = 8;
    };

    // Instantiate registers at specified offsets
    // External registers interface directly with FIFOs (no internal storage)
    external tx_data_reg      tx_data      @ 0x00;
    external rx_data_reg      rx_data      @ 0x04;
    status_reg                status       @ 0x08;
    control_reg               control      @ 0x0C;
    external tx_level_reg     tx_level     @ 0x10;
    external rx_level_reg     rx_level     @ 0x14;
    flush_timeout_reg         flush_timeout @ 0x18;
    flush_thresh_reg          flush_thresh @ 0x1C;
    flush_char_reg            flush_char   @ 0x20;
    tx_watermark_reg          tx_watermark @ 0x24;
    rx_watermark_reg          rx_watermark @ 0x28;
};
